* Case 1: Valid RC Low-Pass Filter (fc = 1000 Hz)
Vin in 0 AC 1.0
R1 in out 1k
C1 out 0 159.15n
.ac dec 100 10 100k
.control
run
wrdata out_valid.txt vm(out)
quit
.endc
.end
